// SPDX-License-Identifier: CC0-1.0
// SPDX-FileCopyrightText: 2026 RVLab Student Project

// Register interface of the int8 GEMM accelerator (student_gemm.sv).
//
// One job computes, for a tile of N_ROWS activation rows and M weight rows:
//
//   C[m][t] = sum_{k=0}^{K-1} A[t][k] * W[m][k]
//
//   A : N_ROWS x K  int16   at A_ADDR, row-major, rows A_STRIDE bytes apart
//                           (0 = contiguous, i.e. K*2)
//   W : M      x K  int8    at W_ADDR, row-major, rows W_STRIDE bytes apart
//                           (0 = contiguous, i.e. K)
//   C : M x N_ROWS  int32   at C_ADDR, one contiguous run of N_ROWS words per
//                           m, consecutive m separated by C_STRIDE bytes
//
// The transposed C layout keeps every burst the accelerator writes contiguous,
// which matters because the DDR3 last-level cache is direct-mapped.
//
// Constraints (software must check CAPS and fall back to the C kernel):
//   K   multiple of 4, 4 <= K <= CAPS.KMAX
//   N   1 <= N_ROWS <= CAPS.NROWS
//   all three addresses 4-byte aligned, both strides multiples of 4
//
// Two extras around the GEMM:
//   S_ADDR != 0  : after draining weight row m the block also writes the
//                  {max, min} of that row's N_ROWS accumulators to
//                  S_ADDR + m*8 -- the per-row range the requantisation needs,
//                  without software reading the whole accumulator matrix.
//   CTRL.requant : a separate job type that turns an int32 accumulator matrix
//                  into int16 activations with per-row multiplier, shift and
//                  bias (see the ctrl register), transposing [m][n] -> [n][m].
//   CTRL.gather  : the A tile of a GEMM job is gathered straight from an
//                  NHWC image, one kernel position at a time with zeros
//                  outside the image -- the im2col a convolution needs,
//                  without software ever building the patch matrix.
//
// A stride larger than the row lets a job read a column slice of a wider
// matrix: software uses it to split a reduction longer than KMAX into chunks
// (partial sums are added on the CPU), and it is what an attention head's
// Q x K^T needs, since q and k are 64-wide slices of 2304-byte qkv rows.

{
  name: "student_gemm"
  clock_primary: sys_clk
  bus_device: tlul
  bus_host: none
  available_input_list: []
  available_output_list: []
  regwidth: "32"
  registers:
  [
    {
      name: status
      desc: "Status flags"
      swaccess: ro
      hwaccess: hwo
      hwext: "true"
      fields:
      [
        {
          bits: 2:0
          name: "val"
          desc: "bit0 = busy, bit1 = done (job finished since last start), bit2 = bus error latched"
        }
      ]
    }
    {
      name: ctrl
      desc: "Command. Writing start while idle latches the configuration and runs one job."
      swaccess: wo
      hwaccess: hro
      hwext: "true"
      hwqe: "true"
      fields:
      [
        {
          bits: 0
          name: "start"
          desc: "1 - start a job"
        }
        {
          bits: 3
          name: "add"
          desc: "Requantisation job only: 1 - add a residual. With h the requantised value, out[n][m] = sat14(((x[n][m]*ADD_MULT_X + r) >> sx) + ((h*ADD_MULT_H + r) >> sh)), x read from X_ADDR + n*C_STRIDE + m*2, rounding as for the requantisation. M_LEN at most CAPS.KMAX/4."
        }
        {
          bits: 4
          name: "relu"
          desc: "Requantisation job only: 1 - clamp the final output below at 0."
        }
        {
          bits: 5
          name: "lut"
          desc: "Requantisation job only: 1 - map the final output v (after add and ReLU) through the lookup table: out = LUT[v + 8192], an int16. Used for GELU. Present when CAPS bit 24 is set."
        }
        {
          bits: 6
          name: "lut_load"
          desc: "Requantisation job only: 1 - first load the lookup table from LUT_ADDR: 8192 words, word i holding LUT[2i] in bits 15:0 and LUT[2i+1] in bits 31:16. The table is kept for later jobs."
        }
        {
          bits: 7
          name: "a16"
          desc: "Requantisation job only: 1 - the input acc[m][n] is int16 instead of int32: rows of N_ROWS int16 (N_ROWS even), two per word, rows A_STRIDE bytes apart. Present when CAPS bit 25 is set."
        }
        {
          bits: 8
          name: "w16"
          desc: "GEMM job only: 1 - the weights W are int16, two per word (bits 15:0 first), instead of four int8. K_LEN must be even; W_STRIDE 0 then means K*2. Present when CAPS bit 26 is set."
        }
        {
          bits: 9
          name: "ostats"
          desc: "Requantisation job only: 1 - after the output, write each output row n's largest and smallest final value to S_ADDR + n*4 as one word, max in bits 31:16 and min in bits 15:0 (int16). Present when CAPS bit 27 is set."
        }
        {
          bits: 10
          name: "onchip"
          desc: "1 - use the result RAM (131072 words). GEMM job: the accumulators go to that RAM at C_ADDR + m*C_STRIDE + t, both in words, instead of to memory; S_ADDR still receives the statistics. Requantisation job: the input is read from that RAM at A_ADDR + m*A_STRIDE + n, in words (int32 only). Present when CAPS bit 28 is set."
        }
        {
          bits: 11
          name: "greuse"
          desc: "Gather GEMM job, stride 1, one chunk of all k*k kernel positions starting at (0, 0): 1 - a tile row copies the taps kx = 0..k-2 from the previous tile row (its taps kx+1) when both pixels are on one output row, instead of reading them again. The result is the same. Present when CAPS bit 29 is set."
        }
        {
          bits: 12
          name: "osums"
          desc: "Requantisation job with CTRL.ostats: 1 - write four words per output row n to S_ADDR + n*16: {max, min} as with ostats, the sum of the row's final values (int32), and the sum of their squares, bits 31:0 then bits 39:32. Present when CAPS bit 30 is set."
        }
        {
          bits: 13
          name: "grelu"
          desc: "Gather GEMM job: 1 - the job reads relu(image): every int16 value read from G_ADDR that is negative enters the tile as 0. Present when CAPS bit 31 is set."
        }
        {
          bits: 2
          name: "gather"
          desc: "GEMM job only: 1 - the A tile is gathered from an NHWC int16 image as im2col would lay it out (G_ADDR, G_GEOM, G_CHAN, G_CONV, G_START), instead of read from A_ADDR. K_LEN must equal kpos_count * C. C must be even."
        }
        {
          bits: 1
          name: "requant"
          desc: "0 - GEMM job. 1 - requantisation job: A_ADDR/A_STRIDE address an int32 acc[m][n] chunk (M_LEN rows m, N_ROWS columns n, N_ROWS <= CAPS.NROWS, M_LEN <= CAPS.KMAX/2, M_LEN even), P_ADDR a table of {mult, shift, bias} words per row m, and the block writes out[n][m] = sat14((acc*mult + 2^(shift-1)) >> shift + bias) as int16 to C_ADDR + n*C_STRIDE + m*2."
        }
      ]
    }
    {
      name: a_addr
      desc: "Byte address of the activation tile (int16, N_ROWS x K). Must be 4-byte aligned."
      swaccess: rw
      hwaccess: hro
      fields:
      [
        {
          bits: 31:0
          name: "val"
          desc: ""
        }
      ]
    }
    {
      name: w_addr
      desc: "Byte address of the weight matrix (int8, M x K). Must be 4-byte aligned."
      swaccess: rw
      hwaccess: hro
      fields:
      [
        {
          bits: 31:0
          name: "val"
          desc: ""
        }
      ]
    }
    {
      name: c_addr
      desc: "Byte address of the first output run (int32). Must be 4-byte aligned."
      swaccess: rw
      hwaccess: hro
      fields:
      [
        {
          bits: 31:0
          name: "val"
          desc: ""
        }
      ]
    }
    {
      name: c_stride
      desc: "Byte distance between the output runs of consecutive weight rows m."
      swaccess: rw
      hwaccess: hro
      fields:
      [
        {
          bits: 31:0
          name: "val"
          desc: ""
        }
      ]
    }
    {
      name: k_len
      desc: "Reduction length K. Multiple of 4, at most CAPS.KMAX."
      swaccess: rw
      hwaccess: hro
      fields:
      [
        {
          bits: 15:0
          name: "val"
          desc: ""
        }
      ]
    }
    {
      name: m_len
      desc: "Number of weight rows M."
      swaccess: rw
      hwaccess: hro
      fields:
      [
        {
          bits: 15:0
          name: "val"
          desc: ""
        }
      ]
    }
    {
      name: n_rows
      desc: "Number of activation rows in this tile, at most CAPS.NROWS."
      swaccess: rw
      hwaccess: hro
      fields:
      [
        {
          bits: 7:0
          name: "val"
          desc: ""
        }
      ]
    }
    {
      name: caps
      desc: "Hardware capabilities: bits [7:0] = NROWS, bits [23:8] = KMAX, bit 24 = the requantisation lookup table (CTRL.lut) exists, bit 25 = the int16 requantisation input (CTRL.a16) exists, bit 26 = int16 GEMM weights (CTRL.w16) exist, bit 27 = requantisation output row statistics (CTRL.ostats) exist, bit 28 = the result RAM (CTRL.onchip) exists, bit 29 = tap reuse in gather jobs (CTRL.greuse) exists, bit 30 = output row sums (CTRL.osums) exist, bit 31 = ReLU on the gathered image (CTRL.grelu) exists. Reads 0 when no accelerator is present."
      swaccess: ro
      hwaccess: hwo
      hwext: "true"
      fields:
      [
        {
          bits: 31:0
          name: "val"
          desc: ""
        }
      ]
    }
    {
      name: cycles
      desc: "Cycles the last (or current) job has been busy."
      swaccess: ro
      hwaccess: hwo
      hwext: "true"
      fields:
      [
        {
          bits: 31:0
          name: "val"
          desc: ""
        }
      ]
    }
    {
      name: dbg
      desc: "Internal state, for diagnosing a stalled job on hardware."
      swaccess: ro
      hwaccess: hwo
      hwext: "true"
      fields:
      [
        {
          bits: 31:0
          name: "val"
          desc: "[2:0] state, [7:4] rb_cnt, [11:8] wr_out, [12] areq_valid, [13] a_ready, [14] d_valid, [15] err, [31:16] rd_left"
        }
      ]
    }
    {
      name: dbg2
      desc: "Address of the request currently presented on the host A channel."
      swaccess: ro
      hwaccess: hwo
      hwext: "true"
      fields:
      [
        {
          bits: 31:0
          name: "val"
          desc: ""
        }
      ]
    }
    {
      name: dbg3
      desc: "Requests accepted (a_valid & a_ready) since the job started."
      swaccess: ro
      hwaccess: hwo
      hwext: "true"
      fields:
      [
        {
          bits: 31:0
          name: "val"
          desc: ""
        }
      ]
    }
    {
      name: dbg4
      desc: "[15:0] responses received (d_valid) since the job started, [31:16] retries performed after a lost response. Packed as {retry_n_q, rsp_cnt_q} -- see student_gemm.sv."
      swaccess: ro
      hwaccess: hwo
      hwext: "true"
      fields:
      [
        {
          bits: 31:0
          name: "val"
          desc: ""
        }
      ]
    }
      {
      name: a_stride
      desc: "Bytes between consecutive rows of A. 0 means contiguous (K*2). Multiple of 4."
      swaccess: rw
      hwaccess: hro
      fields:
      [
        {
          bits: 31:0
          name: "val"
          desc: ""
        }
      ]
    }
    {
      name: w_stride
      desc: "Bytes between consecutive rows of W. 0 means contiguous (K). Multiple of 4."
      swaccess: rw
      hwaccess: hro
      fields:
      [
        {
          bits: 31:0
          name: "val"
          desc: ""
        }
      ]
    }
      {
      name: s_addr
      desc: "GEMM job: byte address for per-row accumulator statistics, {max, min} int32 at S_ADDR + m*8 for every weight row m. 0 disables. Requantisation job with CTRL.ostats: the output row statistics, one word per output row n (see CTRL.ostats). 4-byte aligned."
      swaccess: rw
      hwaccess: hro
      fields:
      [
        {
          bits: 31:0
          name: "val"
          desc: ""
        }
      ]
    }
    {
      name: p_addr
      desc: "Requantisation job: byte address of the parameter table, three words {mult, shift, bias} per row m. 4-byte aligned."
      swaccess: rw
      hwaccess: hro
      fields:
      [
        {
          bits: 31:0
          name: "val"
          desc: ""
        }
      ]
    }
      {
      name: rq_amax
      desc: "Requantisation job: largest |out| written by the job just finished (0..8191)."
      swaccess: ro
      hwaccess: hwo
      hwext: "true"
      fields:
      [
        {
          bits: 31:0
          name: "val"
          desc: ""
        }
      ]
    }
    {
      name: g_addr
      desc: "Gather: byte address of the input image, int16 NHWC (pixel-major, C channels per pixel). 4-byte aligned."
      swaccess: rw
      hwaccess: hro
      fields:
      [
        {
          bits: 31:0
          name: "val"
          desc: ""
        }
      ]
    }
    {
      name: g_geom
      desc: "Gather: input image height (bits 31:16) and width (bits 15:0) in pixels."
      swaccess: rw
      hwaccess: hro
      fields:
      [
        {
          bits: 31:0
          name: "val"
          desc: ""
        }
      ]
    }
    {
      name: g_chan
      desc: "Gather: output width in pixels (bits 31:16) and channels C (bits 15:0, even)."
      swaccess: rw
      hwaccess: hro
      fields:
      [
        {
          bits: 31:0
          name: "val"
          desc: ""
        }
      ]
    }
    {
      name: g_conv
      desc: "Gather: kernel size k (bits 3:0), stride (7:4), padding (11:8), first kernel row ky (15:12), first kernel column kx (19:16), number of kernel positions in this job (27:20). Positions advance kx then ky, row-major."
      swaccess: rw
      hwaccess: hro
      fields:
      [
        {
          bits: 31:0
          name: "val"
          desc: ""
        }
      ]
    }
    {
      name: g_start
      desc: "Gather: output pixel where the tile's first row lies: oy (bits 31:16), ox (bits 15:0). Rows advance ox, wrapping to the next oy at the output width."
      swaccess: rw
      hwaccess: hro
      fields:
      [
        {
          bits: 31:0
          name: "val"
          desc: ""
        }
      ]
    }
      {
      name: x_addr
      desc: "Requantisation job with CTRL.add: byte address of the residual chunk, int16, same layout as the output (rows C_STRIDE apart). 4-byte aligned."
      swaccess: rw
      hwaccess: hro
      fields:
      [
        {
          bits: 31:0
          name: "val"
          desc: ""
        }
      ]
    }
    {
      name: add_mult_x
      desc: "Requantisation job with CTRL.add: multiplier applied to the residual."
      swaccess: rw
      hwaccess: hro
      fields:
      [
        {
          bits: 31:0
          name: "val"
          desc: ""
        }
      ]
    }
    {
      name: add_mult_h
      desc: "Requantisation job with CTRL.add: multiplier applied to the requantised value."
      swaccess: rw
      hwaccess: hro
      fields:
      [
        {
          bits: 31:0
          name: "val"
          desc: ""
        }
      ]
    }
    {
      name: add_shift
      desc: "Requantisation job with CTRL.add: shift for the residual (bits 5:0) and for the requantised value (bits 13:8)."
      swaccess: rw
      hwaccess: hro
      fields:
      [
        {
          bits: 31:0
          name: "val"
          desc: ""
        }
      ]
    }
    {
      name: lut_addr
      desc: "Requantisation job with CTRL.lut_load: byte address of the lookup table, 8192 words. 4-byte aligned."
      swaccess: rw
      hwaccess: hro
      fields:
      [
        {
          bits: 31:0
          name: "val"
          desc: ""
        }
      ]
    }
  ]
}

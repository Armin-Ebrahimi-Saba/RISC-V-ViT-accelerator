// SPDX-License-Identifier: CC0-1.0
// SPDX-FileCopyrightText: 2026 RVLab Student Project

// Register interface of the int8 GEMM accelerator (student_gemm.sv).
//
// One job computes, for a tile of N_ROWS activation rows and M weight rows:
//
//   C[m][t] = sum_{k=0}^{K-1} A[t][k] * W[m][k]
//
//   A : N_ROWS x K  int16   at A_ADDR, row-major, rows A_STRIDE bytes apart
//                           (0 = contiguous, i.e. K*2)
//   W : M      x K  int8    at W_ADDR, row-major, rows W_STRIDE bytes apart
//                           (0 = contiguous, i.e. K)
//   C : M x N_ROWS  int32   at C_ADDR, one contiguous run of N_ROWS words per
//                           m, consecutive m separated by C_STRIDE bytes
//
// The transposed C layout keeps every burst the accelerator writes contiguous,
// which matters because the DDR3 last-level cache is direct-mapped.
//
// Constraints (software must check CAPS and fall back to the C kernel):
//   K   multiple of 4, 4 <= K <= CAPS.KMAX
//   N   1 <= N_ROWS <= CAPS.NROWS
//   all three addresses 4-byte aligned, both strides multiples of 4
//
// Two extras around the GEMM:
//   S_ADDR != 0  : after draining weight row m the block also writes the
//                  {max, min} of that row's N_ROWS accumulators to
//                  S_ADDR + m*8 -- the per-row range the requantisation needs,
//                  without software reading the whole accumulator matrix.
//   CTRL.requant : a separate job type that turns an int32 accumulator matrix
//                  into int16 activations with per-row multiplier, shift and
//                  bias (see the ctrl register), transposing [m][n] -> [n][m].
//   CTRL.gather  : the A tile of a GEMM job is gathered straight from an
//                  NHWC image, one kernel position at a time with zeros
//                  outside the image -- the im2col a convolution needs,
//                  without software ever building the patch matrix.
//
// A stride larger than the row lets a job read a column slice of a wider
// matrix: software uses it to split a reduction longer than KMAX into chunks
// (partial sums are added on the CPU), and it is what an attention head's
// Q x K^T needs, since q and k are 64-wide slices of 2304-byte qkv rows.

{
  name: "student_gemm"
  clock_primary: sys_clk
  bus_device: tlul
  bus_host: none
  available_input_list: []
  available_output_list: []
  regwidth: "32"
  registers:
  [
    {
      name: status
      desc: "Status flags"
      swaccess: ro
      hwaccess: hwo
      hwext: "true"
      fields:
      [
        {
          bits: 2:0
          name: "val"
          desc: "bit0 = busy, bit1 = done (job finished since last start), bit2 = bus error latched"
        }
      ]
    }
    {
      name: ctrl
      desc: "Command. Writing start while idle latches the configuration and runs one job."
      swaccess: wo
      hwaccess: hro
      hwext: "true"
      hwqe: "true"
      fields:
      [
        {
          bits: 0
          name: "start"
          desc: "1 - start a job"
        }
        {
          bits: 3
          name: "add"
          desc: "Requantisation job only: 1 - add a residual. With h the requantised value, out[n][m] = sat14(((x[n][m]*ADD_MULT_X + r) >> sx) + ((h*ADD_MULT_H + r) >> sh)), x read from X_ADDR + n*C_STRIDE + m*2, rounding as for the requantisation. M_LEN at most CAPS.KMAX/4."
        }
        {
          bits: 4
          name: "relu"
          desc: "Requantisation job only: 1 - clamp the final output below at 0."
        }
        {
          bits: 5
          name: "lut"
          desc: "Requantisation job only: 1 - map the final output v (after add and ReLU) through the lookup table: out = LUT[v + 8192], an int16. Used for GELU. Present when CAPS bit 24 is set."
        }
        {
          bits: 6
          name: "lut_load"
          desc: "Requantisation job only: 1 - first load the lookup table from LUT_ADDR: 8192 words, word i holding LUT[2i] in bits 15:0 and LUT[2i+1] in bits 31:16. The table is kept for later jobs."
        }
        {
          bits: 7
          name: "a16"
          desc: "Requantisation job only: 1 - the input acc[m][n] is int16 instead of int32: rows of N_ROWS int16 (N_ROWS even), two per word, rows A_STRIDE bytes apart. Present when CAPS bit 25 is set."
        }
        {
          bits: 8
          name: "w16"
          desc: "GEMM job only: 1 - the weights W are int16, two per word (bits 15:0 first), instead of four int8. K_LEN must be even; W_STRIDE 0 then means K*2. Present when CAPS bit 26 is set."
        }
        {
          bits: 9
          name: "ostats"
          desc: "Requantisation job only: 1 - after the output, write each output row n's largest and smallest final value to S_ADDR + n*4 as one word, max in bits 31:16 and min in bits 15:0 (int16). Present when CAPS bit 27 is set."
        }
        {
          bits: 10
          name: "onchip"
          desc: "1 - use the result RAM (131072 words). GEMM job: the accumulators go to that RAM at C_ADDR + m*C_STRIDE + t, both in words, instead of to memory; S_ADDR still receives the statistics. Requantisation job: the input is read from that RAM at A_ADDR + m*A_STRIDE + n, in words (int32 only). Present when CAPS bit 28 is set."
        }
        {
          bits: 11
          name: "greuse"
          desc: "Gather GEMM job, stride 1, one chunk of all k*k kernel positions starting at (0, 0): 1 - a tile row copies the taps kx = 0..k-2 from the previous tile row (its taps kx+1) when both pixels are on one output row, instead of reading them again. The result is the same. Present when CAPS bit 29 is set."
        }
        {
          bits: 12
          name: "osums"
          desc: "Requantisation job with CTRL.ostats: 1 - write four words per output row n to S_ADDR + n*16: {max, min} as with ostats, the sum of the row's final values (int32), and the sum of their squares, bits 31:0 then bits 39:32. Present when CAPS bit 30 is set."
        }
        {
          bits: 13
          name: "grelu"
          desc: "Gather GEMM job: 1 - the job reads relu(image): every int16 value read from G_ADDR that is negative enters the tile as 0. Present when CAPS bit 31 is set."
        }
        {
          bits: "17:14"
          name: "wsh"
          desc: "GEMM job with CTRL.w16: the int16 weights enter the multipliers shifted right by this amount (arithmetic). No CAPS bit: the driver's self-test finds out whether it exists."
        }
        {
          bits: 18
          name: "lutint"
          desc: "Requantisation job with CTRL.lut: the table holds 257 points L[0..256], word i = {L[i+1], L[i]} (256 words, so a table load reads 256 words); a value v maps to L[i] + (((L[i+1] - L[i]) * f) >> 6) with u = v + 8192, i = u >> 6, f = u & 63 (arithmetic shift). No CAPS bit: the driver's self-test finds out whether it exists."
        }
        {
          bits: 19
          name: "lerp"
          desc: "LERP job (not requant, not gather): N_ROWS = 2 rows of K_LEN int16 are loaded as an A tile (A_ADDR, A_STRIDE); word j of the output at C_ADDR + 4j is, per int16 lane, t + (((b - t) * w) >> 8) (arithmetic) with t from row 0, b from row 1 and w = ADD_MULT_X[8:0]. No CAPS bit: the driver's self-test finds out whether it exists."
        }
        {
          bits: 20
          name: "ln"
          desc: "LayerNorm job, phase A (not requant, not gather, not lerp; without lnb): the per-token parameter table (3 words per token, P_ADDR, M_LEN = N_ROWS tokens), gamma (K_LEN int32 at W_ADDR) and beta (K_LEN int32 at X_ADDR) are loaded, then the tile: N_ROWS tokens of K_LEN int16 channels (A_ADDR, A_STRIDE). Every element becomes zq = sat14(round(x * mult_t / 2^shift_t) + bias_t) in the tile; per channel c the extremes lo, hi of zq give y = ((z * (gamma_c * LN_ZS)) >> 31) + beta_c at z = lo and z = hi, and LN_YMAX is the largest |y|. Nothing is written. Present when CAPS bit 23 is set."
        }
        {
          bits: 21
          name: "lnb"
          desc: "With ln: phase B, which must follow phase A with no other job in between. Per channel G_c = mulh(gamma_c << 12, LN_FM) >> LN_SH.rr and B_c = (mulh(beta_c, LN_INVM) + 2^(LN_SH.bsr - 1)) >> LN_SH.bsr; then out[t][c] = sat14(round(zq * G_c / 2^LN_SH.shift) + B_c), written row by row at C_ADDR + t*C_STRIDE (two channels per word). RQ_AMAX is the largest |out|."
        }
        {
          bits: 22
          name: "rng"
          desc: "GEMM job: after draining weight row m (max and min of its accumulators), hv = mulh(max, S_m) + bv_m and lv = mulh(min, S_m) + bv_m with S_m = align(s_m, ES), B_m = align(b_m, EB), bv_m = mulh(B_m, RNG_BETA.m) >> RNG_BETA.sh; RNG_VMAX = max(0, all hv), RNG_VMIN = min(0, all lv). align(x, e) = x.m >> (x.sh - e), 0 or -1 for shifts over 31. Present when CAPS bit 22 is set."
        }
        {
          bits: 23
          name: "rng_load"
          desc: "With rng: first load the table: M_LEN {m, sh} pairs at RNG_S_ADDR, and at RNG_B_ADDR (0 = no bias), aligned to RNG_E; and start RNG_VMAX, RNG_VMIN from 0."
        }
        {
          bits: 24
          name: "dpar"
          desc: "Requantisation job: the parameters of chunk row i are derived from table row DP_M0 + i instead of read from P_ADDR: mult = mulh(S, DP_FK) >> DP_SH.r, shift = DP_SH.shift, bias = (mulh(B, DP_GB) + 2^(DP_SH.k - 1)) >> DP_SH.k, or 0 with DP_SH.nobias."
        }
        {
          bits: 25
          name: "msums"
          desc: "Requantisation job: at the end, M_LEN words to S_ADDR: each row m's sum over the job's N_ROWS columns of the final values (int32), instead of the output row statistics. Present when CAPS bit 21 is set."
        }
        {
          bits: 26
          name: "nparam"
          desc: "Requantisation job: the parameter table has N_ROWS rows, and output row n uses row n's {mult, shift, bias} (instead of M_LEN rows, one per m)."
        }
        {
          bits: 27
          name: "sat16"
          desc: "Requantisation job: saturate at +-32767 instead of +-8191 (not with CTRL.lut or CTRL.add)."
        }
        {
          bits: 2
          name: "gather"
          desc: "GEMM job only: 1 - the A tile is gathered from an NHWC int16 image as im2col would lay it out (G_ADDR, G_GEOM, G_CHAN, G_CONV, G_START), instead of read from A_ADDR. K_LEN must equal kpos_count * C. C must be even."
        }
        {
          bits: 1
          name: "requant"
          desc: "0 - GEMM job. 1 - requantisation job: A_ADDR/A_STRIDE address an int32 acc[m][n] chunk (M_LEN rows m, N_ROWS columns n, N_ROWS <= CAPS.NROWS, M_LEN <= CAPS.KMAX/2, M_LEN even), P_ADDR a table of {mult, shift, bias} words per row m, and the block writes out[n][m] = sat14((acc*mult + 2^(shift-1)) >> shift + bias) as int16 to C_ADDR + n*C_STRIDE + m*2."
        }
      ]
    }
    {
      name: a_addr
      desc: "Byte address of the activation tile (int16, N_ROWS x K). Must be 4-byte aligned."
      swaccess: rw
      hwaccess: hro
      fields:
      [
        {
          bits: 31:0
          name: "val"
          desc: ""
        }
      ]
    }
    {
      name: w_addr
      desc: "Byte address of the weight matrix (int8, M x K). Must be 4-byte aligned."
      swaccess: rw
      hwaccess: hro
      fields:
      [
        {
          bits: 31:0
          name: "val"
          desc: ""
        }
      ]
    }
    {
      name: c_addr
      desc: "Byte address of the first output run (int32). Must be 4-byte aligned."
      swaccess: rw
      hwaccess: hro
      fields:
      [
        {
          bits: 31:0
          name: "val"
          desc: ""
        }
      ]
    }
    {
      name: c_stride
      desc: "Byte distance between the output runs of consecutive weight rows m."
      swaccess: rw
      hwaccess: hro
      fields:
      [
        {
          bits: 31:0
          name: "val"
          desc: ""
        }
      ]
    }
    {
      name: k_len
      desc: "Reduction length K. Multiple of 4, at most CAPS.KMAX."
      swaccess: rw
      hwaccess: hro
      fields:
      [
        {
          bits: 15:0
          name: "val"
          desc: ""
        }
      ]
    }
    {
      name: m_len
      desc: "Number of weight rows M."
      swaccess: rw
      hwaccess: hro
      fields:
      [
        {
          bits: 15:0
          name: "val"
          desc: ""
        }
      ]
    }
    {
      name: n_rows
      desc: "Number of activation rows in this tile, at most CAPS.NROWS."
      swaccess: rw
      hwaccess: hro
      fields:
      [
        {
          bits: 7:0
          name: "val"
          desc: ""
        }
      ]
    }
    {
      name: caps
      desc: "Hardware capabilities: bits [7:0] = NROWS, bits [23:8] = KMAX, bit 24 = the requantisation lookup table (CTRL.lut) exists, bit 25 = the int16 requantisation input (CTRL.a16) exists, bit 26 = int16 GEMM weights (CTRL.w16) exist, bit 27 = requantisation output row statistics (CTRL.ostats) exist, bit 28 = the result RAM (CTRL.onchip) exists, bit 29 = tap reuse in gather jobs (CTRL.greuse) exists, bit 30 = output row sums (CTRL.osums) exist, bit 31 = ReLU on the gathered image (CTRL.grelu) exists. Reads 0 when no accelerator is present."
      swaccess: ro
      hwaccess: hwo
      hwext: "true"
      fields:
      [
        {
          bits: 31:0
          name: "val"
          desc: ""
        }
      ]
    }
    {
      name: cycles
      desc: "Cycles the last (or current) job has been busy."
      swaccess: ro
      hwaccess: hwo
      hwext: "true"
      fields:
      [
        {
          bits: 31:0
          name: "val"
          desc: ""
        }
      ]
    }
    {
      name: dbg
      desc: "Internal state, for diagnosing a stalled job on hardware."
      swaccess: ro
      hwaccess: hwo
      hwext: "true"
      fields:
      [
        {
          bits: 31:0
          name: "val"
          desc: "[2:0] state, [7:4] rb_cnt, [11:8] wr_out, [12] areq_valid, [13] a_ready, [14] d_valid, [15] err, [31:16] rd_left"
        }
      ]
    }
    {
      name: dbg2
      desc: "Address of the request currently presented on the host A channel."
      swaccess: ro
      hwaccess: hwo
      hwext: "true"
      fields:
      [
        {
          bits: 31:0
          name: "val"
          desc: ""
        }
      ]
    }
    {
      name: dbg3
      desc: "Requests accepted (a_valid & a_ready) since the job started."
      swaccess: ro
      hwaccess: hwo
      hwext: "true"
      fields:
      [
        {
          bits: 31:0
          name: "val"
          desc: ""
        }
      ]
    }
    {
      name: dbg4
      desc: "[15:0] responses received (d_valid) since the job started, [31:16] retries performed after a lost response. Packed as {retry_n_q, rsp_cnt_q} -- see student_gemm.sv."
      swaccess: ro
      hwaccess: hwo
      hwext: "true"
      fields:
      [
        {
          bits: 31:0
          name: "val"
          desc: ""
        }
      ]
    }
      {
      name: a_stride
      desc: "Bytes between consecutive rows of A. 0 means contiguous (K*2). Multiple of 4."
      swaccess: rw
      hwaccess: hro
      fields:
      [
        {
          bits: 31:0
          name: "val"
          desc: ""
        }
      ]
    }
    {
      name: w_stride
      desc: "Bytes between consecutive rows of W. 0 means contiguous (K). Multiple of 4."
      swaccess: rw
      hwaccess: hro
      fields:
      [
        {
          bits: 31:0
          name: "val"
          desc: ""
        }
      ]
    }
      {
      name: s_addr
      desc: "GEMM job: byte address for per-row accumulator statistics, {max, min} int32 at S_ADDR + m*8 for every weight row m. 0 disables. Requantisation job with CTRL.ostats: the output row statistics, one word per output row n (see CTRL.ostats). 4-byte aligned."
      swaccess: rw
      hwaccess: hro
      fields:
      [
        {
          bits: 31:0
          name: "val"
          desc: ""
        }
      ]
    }
    {
      name: p_addr
      desc: "Requantisation job: byte address of the parameter table, three words {mult, shift, bias} per row m. 4-byte aligned."
      swaccess: rw
      hwaccess: hro
      fields:
      [
        {
          bits: 31:0
          name: "val"
          desc: ""
        }
      ]
    }
      {
      name: rq_amax
      desc: "Requantisation job: largest |out| written by the job just finished (0..8191)."
      swaccess: ro
      hwaccess: hwo
      hwext: "true"
      fields:
      [
        {
          bits: 31:0
          name: "val"
          desc: ""
        }
      ]
    }
    {
      name: g_addr
      desc: "Gather: byte address of the input image, int16 NHWC (pixel-major, C channels per pixel). 4-byte aligned."
      swaccess: rw
      hwaccess: hro
      fields:
      [
        {
          bits: 31:0
          name: "val"
          desc: ""
        }
      ]
    }
    {
      name: g_geom
      desc: "Gather: input image height (bits 31:16) and width (bits 15:0) in pixels."
      swaccess: rw
      hwaccess: hro
      fields:
      [
        {
          bits: 31:0
          name: "val"
          desc: ""
        }
      ]
    }
    {
      name: g_chan
      desc: "Gather: output width in pixels (bits 31:16) and channels C (bits 15:0, even)."
      swaccess: rw
      hwaccess: hro
      fields:
      [
        {
          bits: 31:0
          name: "val"
          desc: ""
        }
      ]
    }
    {
      name: g_conv
      desc: "Gather: kernel size k (bits 3:0), stride (7:4), padding (11:8), first kernel row ky (15:12), first kernel column kx (19:16), number of kernel positions in this job (27:20). Positions advance kx then ky, row-major."
      swaccess: rw
      hwaccess: hro
      fields:
      [
        {
          bits: 31:0
          name: "val"
          desc: ""
        }
      ]
    }
    {
      name: g_start
      desc: "Gather: output pixel where the tile's first row lies: oy (bits 31:16), ox (bits 15:0). Rows advance ox, wrapping to the next oy at the output width."
      swaccess: rw
      hwaccess: hro
      fields:
      [
        {
          bits: 31:0
          name: "val"
          desc: ""
        }
      ]
    }
      {
      name: x_addr
      desc: "Requantisation job with CTRL.add: byte address of the residual chunk, int16, same layout as the output (rows C_STRIDE apart). 4-byte aligned."
      swaccess: rw
      hwaccess: hro
      fields:
      [
        {
          bits: 31:0
          name: "val"
          desc: ""
        }
      ]
    }
    {
      name: add_mult_x
      desc: "Requantisation job with CTRL.add: multiplier applied to the residual."
      swaccess: rw
      hwaccess: hro
      fields:
      [
        {
          bits: 31:0
          name: "val"
          desc: ""
        }
      ]
    }
    {
      name: add_mult_h
      desc: "Requantisation job with CTRL.add: multiplier applied to the requantised value."
      swaccess: rw
      hwaccess: hro
      fields:
      [
        {
          bits: 31:0
          name: "val"
          desc: ""
        }
      ]
    }
    {
      name: add_shift
      desc: "Requantisation job with CTRL.add: shift for the residual (bits 5:0) and for the requantised value (bits 13:8)."
      swaccess: rw
      hwaccess: hro
      fields:
      [
        {
          bits: 31:0
          name: "val"
          desc: ""
        }
      ]
    }
    {
      name: lut_addr
      desc: "Requantisation job with CTRL.lut_load: byte address of the lookup table, 8192 words. 4-byte aligned."
      swaccess: rw
      hwaccess: hro
      fields:
      [
        {
          bits: 31:0
          name: "val"
          desc: ""
        }
      ]
    }
    {
      name: ln_zs
      desc: "LayerNorm phase A: ZS, the scale of zq times 2^32 (unsigned, below 2^25)."
      swaccess: rw
      hwaccess: hro
      fields:
      [
        {
          bits: 31:0
          name: "val"
          desc: ""
        }
      ]
    }
    {
      name: ln_fm
      desc: "LayerNorm phase B: the multiplier F.m of the channel multipliers."
      swaccess: rw
      hwaccess: hro
      fields:
      [
        {
          bits: 31:0
          name: "val"
          desc: ""
        }
      ]
    }
    {
      name: ln_invm
      desc: "LayerNorm phase B: the multiplier inv.m of the channel biases."
      swaccess: rw
      hwaccess: hro
      fields:
      [
        {
          bits: 31:0
          name: "val"
          desc: ""
        }
      ]
    }
    {
      name: ln_sh
      desc: "LayerNorm phase B: shift (bits 5:0), rr (bits 12:8), bsr (bits 20:16, 1..30)."
      swaccess: rw
      hwaccess: hro
      fields:
      [
        {
          bits: 31:0
          name: "val"
          desc: ""
        }
      ]
    }
    {
      name: ln_ymax_lo
      desc: "LayerNorm phase A: largest |y|, bits 31:0."
      swaccess: ro
      hwaccess: hwo
      hwext: "true"
      fields:
      [
        {
          bits: 31:0
          name: "val"
          desc: ""
        }
      ]
    }
    {
      name: ln_ymax_hi
      desc: "LayerNorm phase A: largest |y|, bits 63:32."
      swaccess: ro
      hwaccess: hwo
      hwext: "true"
      fields:
      [
        {
          bits: 31:0
          name: "val"
          desc: ""
        }
      ]
    }
    {
      name: rng_s_addr
      desc: "CTRL.rng_load: the scales, M_LEN {m, sh} int32 pairs."
      swaccess: rw
      hwaccess: hro
      fields:
      [
        {
          bits: 31:0
          name: "val"
          desc: ""
        }
      ]
    }
    {
      name: rng_b_addr
      desc: "CTRL.rng_load: the biases, M_LEN {m, sh} int32 pairs; 0 = no bias."
      swaccess: rw
      hwaccess: hro
      fields:
      [
        {
          bits: 31:0
          name: "val"
          desc: ""
        }
      ]
    }
    {
      name: rng_e
      desc: "CTRL.rng_load: ES (bits 15:0) and EB (bits 31:16), signed."
      swaccess: rw
      hwaccess: hro
      fields:
      [
        {
          bits: 31:0
          name: "val"
          desc: ""
        }
      ]
    }
    {
      name: rng_beta_m
      desc: "CTRL.rng: the bias factor's multiplier."
      swaccess: rw
      hwaccess: hro
      fields:
      [
        {
          bits: 31:0
          name: "val"
          desc: ""
        }
      ]
    }
    {
      name: rng_beta_sh
      desc: "CTRL.rng: the bias factor's shift (bits 4:0)."
      swaccess: rw
      hwaccess: hro
      fields:
      [
        {
          bits: 31:0
          name: "val"
          desc: ""
        }
      ]
    }
    {
      name: dp_fk
      desc: "CTRL.dpar: the multiplier factor FK."
      swaccess: rw
      hwaccess: hro
      fields:
      [
        {
          bits: 31:0
          name: "val"
          desc: ""
        }
      ]
    }
    {
      name: dp_gb
      desc: "CTRL.dpar: the bias factor GB."
      swaccess: rw
      hwaccess: hro
      fields:
      [
        {
          bits: 31:0
          name: "val"
          desc: ""
        }
      ]
    }
    {
      name: dp_sh
      desc: "CTRL.dpar: shift (bits 5:0), r (bits 12:8), k (bits 20:16, 1..31), nobias (bit 24)."
      swaccess: rw
      hwaccess: hro
      fields:
      [
        {
          bits: 31:0
          name: "val"
          desc: ""
        }
      ]
    }
    {
      name: dp_m0
      desc: "CTRL.dpar: the table row of the chunk's first row."
      swaccess: rw
      hwaccess: hro
      fields:
      [
        {
          bits: 31:0
          name: "val"
          desc: ""
        }
      ]
    }
    {
      name: rng_vmax_lo
      desc: "CTRL.rng: RNG_VMAX bits 31:0."
      swaccess: ro
      hwaccess: hwo
      hwext: "true"
      fields:
      [
        {
          bits: 31:0
          name: "val"
          desc: ""
        }
      ]
    }
    {
      name: rng_vmax_hi
      desc: "CTRL.rng: RNG_VMAX bits 63:32."
      swaccess: ro
      hwaccess: hwo
      hwext: "true"
      fields:
      [
        {
          bits: 31:0
          name: "val"
          desc: ""
        }
      ]
    }
    {
      name: rng_vmin_lo
      desc: "CTRL.rng: RNG_VMIN bits 31:0."
      swaccess: ro
      hwaccess: hwo
      hwext: "true"
      fields:
      [
        {
          bits: 31:0
          name: "val"
          desc: ""
        }
      ]
    }
    {
      name: rng_vmin_hi
      desc: "CTRL.rng: RNG_VMIN bits 63:32."
      swaccess: ro
      hwaccess: hwo
      hwext: "true"
      fields:
      [
        {
          bits: 31:0
          name: "val"
          desc: ""
        }
      ]
    }
  ]
}

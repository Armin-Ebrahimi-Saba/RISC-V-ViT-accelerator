// SPDX-License-Identifier: CC0-1.0
// SPDX-FileCopyrightText: 2026 RVLab Student Project

// Register interface of the int8 GEMM accelerator (student_gemm.sv).
//
// One job computes, for a tile of N_ROWS activation rows and M weight rows:
//
//   C[m][t] = sum_{k=0}^{K-1} A[t][k] * W[m][k]
//
//   A : N_ROWS x K  int16   at A_ADDR, row-major, rows A_STRIDE bytes apart
//                           (0 = contiguous, i.e. K*2)
//   W : M      x K  int8    at W_ADDR, row-major, rows W_STRIDE bytes apart
//                           (0 = contiguous, i.e. K)
//   C : M x N_ROWS  int32   at C_ADDR, one contiguous run of N_ROWS words per
//                           m, consecutive m separated by C_STRIDE bytes
//
// The transposed C layout keeps every burst the accelerator writes contiguous,
// which matters because the DDR3 last-level cache is direct-mapped.
//
// Constraints (software must check CAPS and fall back to the C kernel):
//   K   multiple of 4, 4 <= K <= CAPS.KMAX
//   N   1 <= N_ROWS <= CAPS.NROWS
//   all three addresses 4-byte aligned, both strides multiples of 4
//
// Two extras around the GEMM:
//   S_ADDR != 0  : after draining weight row m the block also writes the
//                  {max, min} of that row's N_ROWS accumulators to
//                  S_ADDR + m*8 -- the per-row range the requantisation needs,
//                  without software reading the whole accumulator matrix.
//   CTRL.requant : a separate job type that turns an int32 accumulator matrix
//                  into int16 activations with per-row multiplier, shift and
//                  bias (see the ctrl register), transposing [m][n] -> [n][m].
//   CTRL.gather  : the A tile of a GEMM job is gathered straight from an
//                  NHWC image, one kernel position at a time with zeros
//                  outside the image -- the im2col a convolution needs,
//                  without software ever building the patch matrix.
//
// A stride larger than the row lets a job read a column slice of a wider
// matrix: software uses it to split a reduction longer than KMAX into chunks
// (partial sums are added on the CPU), and it is what an attention head's
// Q x K^T needs, since q and k are 64-wide slices of 2304-byte qkv rows.

{
  name: "student_gemm"
  clock_primary: sys_clk
  bus_device: tlul
  bus_host: none
  available_input_list: []
  available_output_list: []
  regwidth: "32"
  registers:
  [
    {
      name: status
      desc: "Status flags"
      swaccess: ro
      hwaccess: hwo
      hwext: "true"
      fields:
      [
        {
          bits: 2:0
          name: "val"
          desc: "bit0 = busy, bit1 = done (job finished since last start), bit2 = bus error latched"
        }
      ]
    }
    {
      name: ctrl
      desc: "Command. Writing start while idle latches the configuration and runs one job."
      swaccess: wo
      hwaccess: hro
      hwext: "true"
      hwqe: "true"
      fields:
      [
        {
          bits: 0
          name: "start"
          desc: "1 - start a job"
        }
        {
          bits: 2
          name: "gather"
          desc: "GEMM job only: 1 - the A tile is gathered from an NHWC int16 image as im2col would lay it out (G_ADDR, G_GEOM, G_CHAN, G_CONV, G_START), instead of read from A_ADDR. K_LEN must equal kpos_count * C. C must be even."
        }
        {
          bits: 1
          name: "requant"
          desc: "0 - GEMM job. 1 - requantisation job: A_ADDR/A_STRIDE address an int32 acc[m][n] chunk (M_LEN rows m, N_ROWS columns n, N_ROWS <= CAPS.NROWS, M_LEN <= CAPS.KMAX/2, M_LEN even), P_ADDR a table of {mult, shift, bias} words per row m, and the block writes out[n][m] = sat14((acc*mult + 2^(shift-1)) >> shift + bias) as int16 to C_ADDR + n*C_STRIDE + m*2."
        }
      ]
    }
    {
      name: a_addr
      desc: "Byte address of the activation tile (int16, N_ROWS x K). Must be 4-byte aligned."
      swaccess: rw
      hwaccess: hro
      fields:
      [
        {
          bits: 31:0
          name: "val"
          desc: ""
        }
      ]
    }
    {
      name: w_addr
      desc: "Byte address of the weight matrix (int8, M x K). Must be 4-byte aligned."
      swaccess: rw
      hwaccess: hro
      fields:
      [
        {
          bits: 31:0
          name: "val"
          desc: ""
        }
      ]
    }
    {
      name: c_addr
      desc: "Byte address of the first output run (int32). Must be 4-byte aligned."
      swaccess: rw
      hwaccess: hro
      fields:
      [
        {
          bits: 31:0
          name: "val"
          desc: ""
        }
      ]
    }
    {
      name: c_stride
      desc: "Byte distance between the output runs of consecutive weight rows m."
      swaccess: rw
      hwaccess: hro
      fields:
      [
        {
          bits: 31:0
          name: "val"
          desc: ""
        }
      ]
    }
    {
      name: k_len
      desc: "Reduction length K. Multiple of 4, at most CAPS.KMAX."
      swaccess: rw
      hwaccess: hro
      fields:
      [
        {
          bits: 15:0
          name: "val"
          desc: ""
        }
      ]
    }
    {
      name: m_len
      desc: "Number of weight rows M."
      swaccess: rw
      hwaccess: hro
      fields:
      [
        {
          bits: 15:0
          name: "val"
          desc: ""
        }
      ]
    }
    {
      name: n_rows
      desc: "Number of activation rows in this tile, at most CAPS.NROWS."
      swaccess: rw
      hwaccess: hro
      fields:
      [
        {
          bits: 7:0
          name: "val"
          desc: ""
        }
      ]
    }
    {
      name: caps
      desc: "Hardware capabilities: bits [7:0] = NROWS, bits [23:8] = KMAX. Reads 0 when no accelerator is present."
      swaccess: ro
      hwaccess: hwo
      hwext: "true"
      fields:
      [
        {
          bits: 31:0
          name: "val"
          desc: ""
        }
      ]
    }
    {
      name: cycles
      desc: "Cycles the last (or current) job has been busy."
      swaccess: ro
      hwaccess: hwo
      hwext: "true"
      fields:
      [
        {
          bits: 31:0
          name: "val"
          desc: ""
        }
      ]
    }
    {
      name: dbg
      desc: "Internal state, for diagnosing a stalled job on hardware."
      swaccess: ro
      hwaccess: hwo
      hwext: "true"
      fields:
      [
        {
          bits: 31:0
          name: "val"
          desc: "[2:0] state, [7:4] rb_cnt, [11:8] wr_out, [12] areq_valid, [13] a_ready, [14] d_valid, [15] err, [31:16] rd_left"
        }
      ]
    }
    {
      name: dbg2
      desc: "Address of the request currently presented on the host A channel."
      swaccess: ro
      hwaccess: hwo
      hwext: "true"
      fields:
      [
        {
          bits: 31:0
          name: "val"
          desc: ""
        }
      ]
    }
    {
      name: dbg3
      desc: "Requests accepted (a_valid & a_ready) since the job started."
      swaccess: ro
      hwaccess: hwo
      hwext: "true"
      fields:
      [
        {
          bits: 31:0
          name: "val"
          desc: ""
        }
      ]
    }
    {
      name: dbg4
      desc: "[15:0] responses received (d_valid) since the job started, [31:16] retries performed after a lost response. Packed as {retry_n_q, rsp_cnt_q} -- see student_gemm.sv."
      swaccess: ro
      hwaccess: hwo
      hwext: "true"
      fields:
      [
        {
          bits: 31:0
          name: "val"
          desc: ""
        }
      ]
    }
      {
      name: a_stride
      desc: "Bytes between consecutive rows of A. 0 means contiguous (K*2). Multiple of 4."
      swaccess: rw
      hwaccess: hro
      fields:
      [
        {
          bits: 31:0
          name: "val"
          desc: ""
        }
      ]
    }
    {
      name: w_stride
      desc: "Bytes between consecutive rows of W. 0 means contiguous (K). Multiple of 4."
      swaccess: rw
      hwaccess: hro
      fields:
      [
        {
          bits: 31:0
          name: "val"
          desc: ""
        }
      ]
    }
      {
      name: s_addr
      desc: "GEMM job: byte address for per-row accumulator statistics, {max, min} int32 at S_ADDR + m*8 for every weight row m. 0 disables. 4-byte aligned."
      swaccess: rw
      hwaccess: hro
      fields:
      [
        {
          bits: 31:0
          name: "val"
          desc: ""
        }
      ]
    }
    {
      name: p_addr
      desc: "Requantisation job: byte address of the parameter table, three words {mult, shift, bias} per row m. 4-byte aligned."
      swaccess: rw
      hwaccess: hro
      fields:
      [
        {
          bits: 31:0
          name: "val"
          desc: ""
        }
      ]
    }
      {
      name: rq_amax
      desc: "Requantisation job: largest |out| written by the job just finished (0..8191)."
      swaccess: ro
      hwaccess: hwo
      hwext: "true"
      fields:
      [
        {
          bits: 31:0
          name: "val"
          desc: ""
        }
      ]
    }
    {
      name: g_addr
      desc: "Gather: byte address of the input image, int16 NHWC (pixel-major, C channels per pixel). 4-byte aligned."
      swaccess: rw
      hwaccess: hro
      fields:
      [
        {
          bits: 31:0
          name: "val"
          desc: ""
        }
      ]
    }
    {
      name: g_geom
      desc: "Gather: input image height (bits 31:16) and width (bits 15:0) in pixels."
      swaccess: rw
      hwaccess: hro
      fields:
      [
        {
          bits: 31:0
          name: "val"
          desc: ""
        }
      ]
    }
    {
      name: g_chan
      desc: "Gather: output width in pixels (bits 31:16) and channels C (bits 15:0, even)."
      swaccess: rw
      hwaccess: hro
      fields:
      [
        {
          bits: 31:0
          name: "val"
          desc: ""
        }
      ]
    }
    {
      name: g_conv
      desc: "Gather: kernel size k (bits 3:0), stride (7:4), padding (11:8), first kernel row ky (15:12), first kernel column kx (19:16), number of kernel positions in this job (27:20). Positions advance kx then ky, row-major."
      swaccess: rw
      hwaccess: hro
      fields:
      [
        {
          bits: 31:0
          name: "val"
          desc: ""
        }
      ]
    }
    {
      name: g_start
      desc: "Gather: output pixel where the tile's first row lies: oy (bits 31:16), ox (bits 15:0). Rows advance ox, wrapping to the next oy at the output width."
      swaccess: rw
      hwaccess: hro
      fields:
      [
        {
          bits: 31:0
          name: "val"
          desc: ""
        }
      ]
    }
  ]
}
